* Dummy SPICE Netlist for Testing Idempotency
.op
.end
